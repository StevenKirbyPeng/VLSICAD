*========================================================
* circuit.spi - Lab8 / Lab9 pre-sim source netlist
* CMOS gates in TSRI CIC 0.18um virtual process
*========================================================

*---------------------
* Inverter
* pins: in out_1 VDD GND
*---------------------
.subckt inv in out_1 VDD GND
MP_inv out_1 in VDD VDD p_18 W=1u   L=0.18u
MN_inv out_1 in GND GND n_18 W=0.5u L=0.18u
.ends inv

*---------------------
* 2-input NAND
* PMOS parallel, NMOS series
* pins: A B out_2 VDD GND
*---------------------
.subckt nand A B out_2 VDD GND
MP_nand_A out_2 A VDD VDD p_18 W=1u   L=0.18u
MP_nand_B out_2 B VDD VDD p_18 W=1u   L=0.18u
MN_nand_A out_2 A n_mid GND n_18 W=0.5u L=0.18u
MN_nand_B n_mid B GND   GND n_18 W=0.5u L=0.18u
.ends nand

*---------------------
* 2-input NOR
* PMOS series, NMOS parallel
* pins: C D out_3 VDD GND
*---------------------
.subckt nor C D out_3 VDD GND
MP_nor_C p_mid C VDD   VDD p_18 W=1u   L=0.18u
MP_nor_D out_3 D p_mid VDD p_18 W=1u   L=0.18u
MN_nor_C out_3 C GND   GND n_18 W=0.5u L=0.18u
MN_nor_D out_3 D GND   GND n_18 W=0.5u L=0.18u
.ends nor
