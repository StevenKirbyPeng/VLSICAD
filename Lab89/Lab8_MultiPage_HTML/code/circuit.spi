*==========================================================
* Lab8 circuit.spi
* CMOS Inverter / NAND / NOR for CIC 0.18um model
* PMOS: W/L = 1u/0.18u
* NMOS: W/L = 0.5u/0.18u
*==========================================================

*** inverter ***
.subckt inv in out_1 VDD GND
Mp_inv out_1 in VDD VDD p_18 W=1u L=0.18u
Mn_inv out_1 in GND GND n_18 W=0.5u L=0.18u
.ends inv

*** 2-input NAND ***
.subckt nand A B out_2 VDD GND
* Pull-up network: PMOS parallel
Mp_nand_A out_2 A VDD VDD p_18 W=1u L=0.18u
Mp_nand_B out_2 B VDD VDD p_18 W=1u L=0.18u
* Pull-down network: NMOS series
Mn_nand_A out_2 A n_nand GND n_18 W=0.5u L=0.18u
Mn_nand_B n_nand B GND GND n_18 W=0.5u L=0.18u
.ends nand

*** 2-input NOR ***
.subckt nor C D out_3 VDD GND
* Pull-up network: PMOS series
Mp_nor_C n_nor C VDD VDD p_18 W=1u L=0.18u
Mp_nor_D out_3 D n_nor VDD p_18 W=1u L=0.18u
* Pull-down network: NMOS parallel
Mn_nor_C out_3 C GND GND n_18 W=0.5u L=0.18u
Mn_nor_D out_3 D GND GND n_18 W=0.5u L=0.18u
.ends nor
